* EQUIVALENT CIRCUIT FOR VECTOR FITTED S-MATRIX
* Created using scikit-rf vectorFitting.py
*
.SUBCKT s_equivalent p1 p2 p3 p4
*
* Port network for port 1
V1 p1 s1 0
R1 s1 0 50.0
Gd1_1 0 s1 p1 0 -0.003430269693361239
Fd1_1 0 s1 V1 -0.17151348466806196
Gr1_1_1 0 s1 x1_a1 0 -77943631620940.28
Gr2_re_1_1 0 s1 x2_re_a1 0 629258017116.0238
Gr2_im_1_1 0 s1 x2_im_a1 0 4869727846683.293
Gr3_re_1_1 0 s1 x3_re_a1 0 275832921950.7436
Gr3_im_1_1 0 s1 x3_im_a1 0 -171427103402.05984
Gr4_re_1_1 0 s1 x4_re_a1 0 84686622514.46434
Gr4_im_1_1 0 s1 x4_im_a1 0 -27028068091.414955
Gr5_1_1 0 s1 x5_a1 0 12890141826.062084
Gr6_re_1_1 0 s1 x6_re_a1 0 -38235054.63568865
Gr6_im_1_1 0 s1 x6_im_a1 0 -9672498.805127814
Gr7_re_1_1 0 s1 x7_re_a1 0 -256254517.61185014
Gr7_im_1_1 0 s1 x7_im_a1 0 -819259100.1571368
Gr8_re_1_1 0 s1 x8_re_a1 0 -3208062247.8737226
Gr8_im_1_1 0 s1 x8_im_a1 0 -157008918.1393038
Gr9_1_1 0 s1 x9_a1 0 3170532461.640877
Gr10_re_1_1 0 s1 x10_re_a1 0 4.306080889543164
Gr10_im_1_1 0 s1 x10_im_a1 0 2.0615546599635444
Gr11_re_1_1 0 s1 x11_re_a1 0 56077471899.064674
Gr11_im_1_1 0 s1 x11_im_a1 0 -10742879771.027233
Gr12_re_1_1 0 s1 x12_re_a1 0 51442518182.09399
Gr12_im_1_1 0 s1 x12_im_a1 0 -5121530331.100692
Gr13_1_1 0 s1 x13_a1 0 -230581959.63827014
Gr14_1_1 0 s1 x14_a1 0 111375887313.81494
Gr15_1_1 0 s1 x15_a1 0 -137708817.6334284
Gd1_2 0 s1 p2 0 0.002828171007136158
Fd1_2 0 s1 V2 0.1414085503568079
Gr1_1_2 0 s1 x1_a2 0 64119545455433.07
Gr2_re_1_2 0 s1 x2_re_a2 0 -1030562389267.6146
Gr2_im_1_2 0 s1 x2_im_a2 0 -1310756703302.4548
Gr3_re_1_2 0 s1 x3_re_a2 0 158965821094.77676
Gr3_im_1_2 0 s1 x3_im_a2 0 20782247972.664417
Gr4_re_1_2 0 s1 x4_re_a2 0 -108314796381.08476
Gr4_im_1_2 0 s1 x4_im_a2 0 29773655417.79181
Gr5_1_2 0 s1 x5_a2 0 2260352586.06027
Gr6_re_1_2 0 s1 x6_re_a2 0 1841311.1890265127
Gr6_im_1_2 0 s1 x6_im_a2 0 7638344.385530283
Gr7_re_1_2 0 s1 x7_re_a2 0 122166298.38119474
Gr7_im_1_2 0 s1 x7_im_a2 0 -173985428.15592846
Gr8_re_1_2 0 s1 x8_re_a2 0 1293590704.033702
Gr8_im_1_2 0 s1 x8_im_a2 0 1399594061.3574014
Gr9_1_2 0 s1 x9_a2 0 -14933562984.594978
Gr10_re_1_2 0 s1 x10_re_a2 0 1.0815577784056902
Gr10_im_1_2 0 s1 x10_im_a2 0 1.3436594885471407
Gr11_re_1_2 0 s1 x11_re_a2 0 -56023787806.25648
Gr11_im_1_2 0 s1 x11_im_a2 0 10697351734.160933
Gr12_re_1_2 0 s1 x12_re_a2 0 51466469426.35728
Gr12_im_1_2 0 s1 x12_im_a2 0 -5088075039.601106
Gr13_1_2 0 s1 x13_a2 0 34383385.20667561
Gr14_1_2 0 s1 x14_a2 0 116308160892.39163
Gr15_1_2 0 s1 x15_a2 0 -21748404.372844364
Gd1_3 0 s1 p3 0 -0.002077036763907541
Fd1_3 0 s1 V3 -0.10385183819537704
Gr1_1_3 0 s1 x1_a3 0 -50055463360829.836
Gr2_re_1_3 0 s1 x2_re_a3 0 523563025157.7086
Gr2_im_1_3 0 s1 x2_im_a3 0 137371961899.19516
Gr3_re_1_3 0 s1 x3_re_a3 0 -127637627104.12292
Gr3_im_1_3 0 s1 x3_im_a3 0 192815039285.1313
Gr4_re_1_3 0 s1 x4_re_a3 0 139966657765.41626
Gr4_im_1_3 0 s1 x4_im_a3 0 -42657539998.80659
Gr5_1_3 0 s1 x5_a3 0 128446735031.1725
Gr6_re_1_3 0 s1 x6_re_a3 0 19069437.583976395
Gr6_im_1_3 0 s1 x6_im_a3 0 7090600.200823769
Gr7_re_1_3 0 s1 x7_re_a3 0 191404073.86166993
Gr7_im_1_3 0 s1 x7_im_a3 0 558733235.1981136
Gr8_re_1_3 0 s1 x8_re_a3 0 2841307410.251324
Gr8_im_1_3 0 s1 x8_im_a3 0 -969901426.457188
Gr9_1_3 0 s1 x9_a3 0 -44589766712.03688
Gr10_re_1_3 0 s1 x10_re_a3 0 -2.061060137199651
Gr10_im_1_3 0 s1 x10_im_a3 0 1.4152403928247228
Gr11_re_1_3 0 s1 x11_re_a3 0 -56034134837.87794
Gr11_im_1_3 0 s1 x11_im_a3 0 10711136474.799362
Gr12_re_1_3 0 s1 x12_re_a3 0 -51442034768.35608
Gr12_im_1_3 0 s1 x12_im_a3 0 5098036655.479865
Gr13_1_3 0 s1 x13_a3 0 281939635.87934446
Gr14_1_3 0 s1 x14_a3 0 119579642112.48442
Gr15_1_3 0 s1 x15_a3 0 -98563859.9227383
Gd1_4 0 s1 p4 0 -0.009635103407965782
Fd1_4 0 s1 V4 -0.48175517039828913
Gr1_1_4 0 s1 x1_a4 0 -221543651945091.2
Gr2_re_1_4 0 s1 x2_re_a4 0 3125957801371.3076
Gr2_im_1_4 0 s1 x2_im_a4 0 4414112250535.665
Gr3_re_1_4 0 s1 x3_re_a4 0 -96805998030.50772
Gr3_im_1_4 0 s1 x3_im_a4 0 -209728993095.60034
Gr4_re_1_4 0 s1 x4_re_a4 0 -132699130916.57611
Gr4_im_1_4 0 s1 x4_im_a4 0 28637381759.72586
Gr5_1_4 0 s1 x5_a4 0 164787899638.4986
Gr6_re_1_4 0 s1 x6_re_a4 0 -3683177.7904071636
Gr6_im_1_4 0 s1 x6_im_a4 0 -9100430.567641791
Gr7_re_1_4 0 s1 x7_re_a4 0 -57282259.2058219
Gr7_im_1_4 0 s1 x7_im_a4 0 208990899.4363161
Gr8_re_1_4 0 s1 x8_re_a4 0 -909709703.80503
Gr8_im_1_4 0 s1 x8_im_a4 0 -1609814299.0931633
Gr9_1_4 0 s1 x9_a4 0 -32334054474.34796
Gr10_re_1_4 0 s1 x10_re_a4 0 -3.7584209428113478
Gr10_im_1_4 0 s1 x10_im_a4 0 -2.9064166675164214
Gr11_re_1_4 0 s1 x11_re_a4 0 56057085926.40201
Gr11_im_1_4 0 s1 x11_im_a4 0 -10708660461.901325
Gr12_re_1_4 0 s1 x12_re_a4 0 -51446473644.13295
Gr12_im_1_4 0 s1 x12_im_a4 0 5114626414.090641
Gr13_1_4 0 s1 x13_a4 0 33318790.172166012
Gr14_1_4 0 s1 x14_a4 0 117547645653.7061
Gr15_1_4 0 s1 x15_a4 0 75467916.69290128
*
* State networks driven by port 1
Cx1_a1 x1_a1 0 1.0
Gx1_a1 0 x1_a1 p1 0 0.07071067811865475
Fx1_a1 0 x1_a1 V1 3.5355339059327378
Rp1_a1 0 x1_a1 5.3127326297329175e-16
Cx2_re_a1 x2_re_a1 0 1.0
Gx2_re_a1 0 x2_re_a1 p1 0 0.1414213562373095
Fx2_re_a1 0 x2_re_a1 V1 7.0710678118654755
Rp2_re_re_a1 0 x2_re_a1 1.4491464268315856e-13
Gp2_re_im_a1 0 x2_re_a1 x2_im_a1 0 4060954945802.302
Cx2_im_a1 x2_im_a1 0 1.0
Gp2_im_re_a1 0 x2_im_a1 x2_re_a1 0 -4060954945802.302
Rp2_im_im_a1 0 x2_im_a1 1.4491464268315856e-13
Cx3_re_a1 x3_re_a1 0 1.0
Gx3_re_a1 0 x3_re_a1 p1 0 0.1414213562373095
Fx3_re_a1 0 x3_re_a1 V1 7.0710678118654755
Rp3_re_re_a1 0 x3_re_a1 9.654530001044516e-13
Gp3_re_im_a1 0 x3_re_a1 x3_im_a1 0 3789070885136.644
Cx3_im_a1 x3_im_a1 0 1.0
Gp3_im_re_a1 0 x3_im_a1 x3_re_a1 0 -3789070885136.644
Rp3_im_im_a1 0 x3_im_a1 9.654530001044516e-13
Cx4_re_a1 x4_re_a1 0 1.0
Gx4_re_a1 0 x4_re_a1 p1 0 0.1414213562373095
Fx4_re_a1 0 x4_re_a1 V1 7.0710678118654755
Rp4_re_re_a1 0 x4_re_a1 1.462282365376178e-12
Gp4_re_im_a1 0 x4_re_a1 x4_im_a1 0 2119527027660.7383
Cx4_im_a1 x4_im_a1 0 1.0
Gp4_im_re_a1 0 x4_im_a1 x4_re_a1 0 -2119527027660.7383
Rp4_im_im_a1 0 x4_im_a1 1.462282365376178e-12
Cx5_a1 x5_a1 0 1.0
Gx5_a1 0 x5_a1 p1 0 0.07071067811865475
Fx5_a1 0 x5_a1 V1 3.5355339059327378
Rp5_a1 0 x5_a1 5.585472429637349e-13
Cx6_re_a1 x6_re_a1 0 1.0
Gx6_re_a1 0 x6_re_a1 p1 0 0.1414213562373095
Fx6_re_a1 0 x6_re_a1 V1 7.0710678118654755
Rp6_re_re_a1 0 x6_re_a1 4.893534373781531e-12
Gp6_re_im_a1 0 x6_re_a1 x6_im_a1 0 1509987609831.2734
Cx6_im_a1 x6_im_a1 0 1.0
Gp6_im_re_a1 0 x6_im_a1 x6_re_a1 0 -1509987609831.2734
Rp6_im_im_a1 0 x6_im_a1 4.893534373781531e-12
Cx7_re_a1 x7_re_a1 0 1.0
Gx7_re_a1 0 x7_re_a1 p1 0 0.1414213562373095
Fx7_re_a1 0 x7_re_a1 V1 7.0710678118654755
Rp7_re_re_a1 0 x7_re_a1 2.29288470403448e-12
Gp7_re_im_a1 0 x7_re_a1 x7_im_a1 0 1394452077308.4116
Cx7_im_a1 x7_im_a1 0 1.0
Gp7_im_re_a1 0 x7_im_a1 x7_re_a1 0 -1394452077308.4116
Rp7_im_im_a1 0 x7_im_a1 2.29288470403448e-12
Cx8_re_a1 x8_re_a1 0 1.0
Gx8_re_a1 0 x8_re_a1 p1 0 0.1414213562373095
Fx8_re_a1 0 x8_re_a1 V1 7.0710678118654755
Rp8_re_re_a1 0 x8_re_a1 1.4913847089427331e-12
Gp8_re_im_a1 0 x8_re_a1 x8_im_a1 0 1216978368828.8792
Cx8_im_a1 x8_im_a1 0 1.0
Gp8_im_re_a1 0 x8_im_a1 x8_re_a1 0 -1216978368828.8792
Rp8_im_im_a1 0 x8_im_a1 1.4913847089427331e-12
Cx9_a1 x9_a1 0 1.0
Gx9_a1 0 x9_a1 p1 0 0.07071067811865475
Fx9_a1 0 x9_a1 V1 3.5355339059327378
Rp9_a1 0 x9_a1 8.726078094748571e-13
Cx10_re_a1 x10_re_a1 0 1.0
Gx10_re_a1 0 x10_re_a1 p1 0 0.1414213562373095
Fx10_re_a1 0 x10_re_a1 V1 7.0710678118654755
Rp10_re_re_a1 0 x10_re_a1 1.3660634868650793e-11
Gp10_re_im_a1 0 x10_re_a1 x10_im_a1 0 1018200886591.4563
Cx10_im_a1 x10_im_a1 0 1.0
Gp10_im_re_a1 0 x10_im_a1 x10_re_a1 0 -1018200886591.4563
Rp10_im_im_a1 0 x10_im_a1 1.3660634868650793e-11
Cx11_re_a1 x11_re_a1 0 1.0
Gx11_re_a1 0 x11_re_a1 p1 0 0.1414213562373095
Fx11_re_a1 0 x11_re_a1 V1 7.0710678118654755
Rp11_re_re_a1 0 x11_re_a1 2.8048472018812475e-12
Gp11_re_im_a1 0 x11_re_a1 x11_im_a1 0 1146809159475.6968
Cx11_im_a1 x11_im_a1 0 1.0
Gp11_im_re_a1 0 x11_im_a1 x11_re_a1 0 -1146809159475.6968
Rp11_im_im_a1 0 x11_im_a1 2.8048472018812475e-12
Cx12_re_a1 x12_re_a1 0 1.0
Gx12_re_a1 0 x12_re_a1 p1 0 0.1414213562373095
Fx12_re_a1 0 x12_re_a1 V1 7.0710678118654755
Rp12_re_re_a1 0 x12_re_a1 3.0396973742463667e-12
Gp12_re_im_a1 0 x12_re_a1 x12_im_a1 0 962334942598.3601
Cx12_im_a1 x12_im_a1 0 1.0
Gp12_im_re_a1 0 x12_im_a1 x12_re_a1 0 -962334942598.3601
Rp12_im_im_a1 0 x12_im_a1 3.0396973742463667e-12
Cx13_a1 x13_a1 0 1.0
Gx13_a1 0 x13_a1 p1 0 0.07071067811865475
Fx13_a1 0 x13_a1 V1 3.5355339059327378
Rp13_a1 0 x13_a1 8.623287421540062e-12
Cx14_a1 x14_a1 0 1.0
Gx14_a1 0 x14_a1 p1 0 0.07071067811865475
Fx14_a1 0 x14_a1 V1 3.5355339059327378
Rp14_a1 0 x14_a1 1.5587977849749075e-12
Cx15_a1 x15_a1 0 1.0
Gx15_a1 0 x15_a1 p1 0 0.07071067811865475
Fx15_a1 0 x15_a1 V1 3.5355339059327378
Rp15_a1 0 x15_a1 7.308577980835905e-12
*
* Port network for port 2
V2 p2 s2 0
R2 s2 0 50.0
Gd2_1 0 s2 p1 0 0.002827855147773821
Fd2_1 0 s2 V1 0.14139275738869106
Gr1_2_1 0 s2 x1_a1 0 64112431667677.97
Gr2_re_2_1 0 s2 x2_re_a1 0 -1030456496566.7505
Gr2_im_2_1 0 s2 x2_im_a1 0 -1310533151223.0583
Gr3_re_2_1 0 s2 x3_re_a1 0 158965197188.31122
Gr3_im_2_1 0 s2 x3_im_a1 0 20771191413.500515
Gr4_re_2_1 0 s2 x4_re_a1 0 -108314827698.36766
Gr4_im_2_1 0 s2 x4_im_a1 0 29772441369.157944
Gr5_2_1 0 s2 x5_a1 0 2277211027.6047807
Gr6_re_2_1 0 s2 x6_re_a1 0 1842374.437038239
Gr6_im_2_1 0 s2 x6_im_a1 0 7636406.214505017
Gr7_re_2_1 0 s2 x7_re_a1 0 122209376.82415031
Gr7_im_2_1 0 s2 x7_im_a1 0 -174009038.81455344
Gr8_re_2_1 0 s2 x8_re_a1 0 1293668366.7814054
Gr8_im_2_1 0 s2 x8_im_a1 0 1399370780.3116949
Gr9_2_1 0 s2 x9_a1 0 -14936534788.274057
Gr10_re_2_1 0 s2 x10_re_a1 0 1.0809689878007378
Gr10_im_2_1 0 s2 x10_im_a1 0 1.3518706165040852
Gr11_re_2_1 0 s2 x11_re_a1 0 -56023786473.32384
Gr11_im_2_1 0 s2 x11_im_a1 0 10697353233.551277
Gr12_re_2_1 0 s2 x12_re_a1 0 51466469236.193596
Gr12_im_2_1 0 s2 x12_im_a1 0 -5088074889.763656
Gr13_2_1 0 s2 x13_a1 0 34400611.53523002
Gr14_2_1 0 s2 x14_a1 0 116308290297.81479
Gr15_2_1 0 s2 x15_a1 0 -21769278.863073573
Gd2_2 0 s2 p2 0 -0.010408660632881088
Fd2_2 0 s2 V2 -0.5204330316440544
Gr1_2_2 0 s2 x1_a2 0 -239469030693400.66
Gr2_re_2_2 0 s2 x2_re_a2 0 2849135022359.0576
Gr2_im_2_2 0 s2 x2_im_a2 0 7585631687951.794
Gr3_re_2_2 0 s2 x3_re_a2 0 134904205052.85345
Gr3_im_2_2 0 s2 x3_im_a2 0 -246088655602.71573
Gr4_re_2_2 0 s2 x4_re_a2 0 77401295646.59846
Gr4_im_2_2 0 s2 x4_im_a2 0 -24631877838.910347
Gr5_2_2 0 s2 x5_a2 0 91657353638.48589
Gr6_re_2_2 0 s2 x6_re_a2 0 -12811353.651980015
Gr6_im_2_2 0 s2 x6_im_a2 0 1469005.985298747
Gr7_re_2_2 0 s2 x7_re_a2 0 -62071918.366065644
Gr7_im_2_2 0 s2 x7_im_a2 0 -749788003.5806617
Gr8_re_2_2 0 s2 x8_re_a2 0 -3082392550.7695727
Gr8_im_2_2 0 s2 x8_im_a2 0 -1183976555.7318652
Gr9_2_2 0 s2 x9_a2 0 -6374201148.393118
Gr10_re_2_2 0 s2 x10_re_a2 0 3.3190740856036896
Gr10_im_2_2 0 s2 x10_im_a2 0 1.0686529350197407
Gr11_re_2_2 0 s2 x11_re_a2 0 55972595991.709236
Gr11_im_2_2 0 s2 x11_im_a2 0 -10667401446.922188
Gr12_re_2_2 0 s2 x12_re_a2 0 51490370933.54915
Gr12_im_2_2 0 s2 x12_im_a2 0 -5056111263.877043
Gr13_2_2 0 s2 x13_a2 0 -218105925.95991442
Gr14_2_2 0 s2 x14_a2 0 111542350615.28271
Gr15_2_2 0 s2 x15_a2 0 -156707697.4109041
Gd2_3 0 s2 p3 0 -0.008821323270288593
Fd2_3 0 s2 V3 -0.4410661635144296
Gr1_2_3 0 s2 x1_a3 0 -203401372220587.4
Gr2_re_2_3 0 s2 x2_re_a3 0 2833178826366.84
Gr2_im_2_3 0 s2 x2_im_a3 0 3815817409705.754
Gr3_re_2_3 0 s2 x3_re_a3 0 -90750484558.68472
Gr3_im_2_3 0 s2 x3_im_a3 0 -173876559475.39575
Gr4_re_2_3 0 s2 x4_re_a3 0 -130536108104.40019
Gr4_im_2_3 0 s2 x4_im_a3 0 31678516713.470608
Gr5_2_3 0 s2 x5_a3 0 131535516416.78674
Gr6_re_2_3 0 s2 x6_re_a3 0 5748146.43011425
Gr6_im_2_3 0 s2 x6_im_a3 0 -6936389.200372684
Gr7_re_2_3 0 s2 x7_re_a3 0 -50176429.70588629
Gr7_im_2_3 0 s2 x7_im_a3 0 282328901.96310955
Gr8_re_2_3 0 s2 x8_re_a3 0 -784878718.4203254
Gr8_im_2_3 0 s2 x8_im_a3 0 -1247137290.1521769
Gr9_2_3 0 s2 x9_a3 0 -27244788395.06403
Gr10_re_2_3 0 s2 x10_re_a3 0 -3.516439169527073
Gr10_im_2_3 0 s2 x10_im_a3 0 -3.4670817006453474
Gr11_re_2_3 0 s2 x11_re_a3 0 55982989801.20237
Gr11_im_2_3 0 s2 x11_im_a3 0 -10664297211.949362
Gr12_re_2_3 0 s2 x12_re_a3 0 -51465917729.36808
Gr12_im_2_3 0 s2 x12_im_a3 0 5063690614.009265
Gr13_2_3 0 s2 x13_a3 0 -4036611.236459088
Gr14_2_3 0 s2 x14_a3 0 117215916340.28513
Gr15_2_3 0 s2 x15_a3 0 119621620.87687656
Gd2_4 0 s2 p4 0 0.00554067279514452
Fd2_4 0 s2 V4 0.277033639757226
Gr1_2_4 0 s2 x1_a4 0 125640206494428.56
Gr2_re_2_4 0 s2 x2_re_a4 0 -1936002976725.4998
Gr2_im_2_4 0 s2 x2_im_a4 0 -3054695184769.5947
Gr3_re_2_4 0 s2 x3_re_a4 0 19005086524.981087
Gr3_im_2_4 0 s2 x3_im_a4 0 296515613523.2798
Gr4_re_2_4 0 s2 x4_re_a4 0 149269262166.01395
Gr4_im_2_4 0 s2 x4_im_a4 0 -42051220251.74143
Gr5_2_4 0 s2 x5_a4 0 29798683374.505535
Gr6_re_2_4 0 s2 x6_re_a4 0 4983543.057528462
Gr6_im_2_4 0 s2 x6_im_a4 0 -1643159.6989925522
Gr7_re_2_4 0 s2 x7_re_a4 0 40116497.655168034
Gr7_im_2_4 0 s2 x7_im_a4 0 552009780.3546149
Gr8_re_2_4 0 s2 x8_re_a4 0 2922763746.1373134
Gr8_im_2_4 0 s2 x8_im_a4 0 309126632.58402556
Gr9_2_4 0 s2 x9_a4 0 -32773260293.412457
Gr10_re_2_4 0 s2 x10_re_a4 0 -1.6242147002906104
Gr10_im_2_4 0 s2 x10_im_a4 0 2.297852359997165
Gr11_re_2_4 0 s2 x11_re_a4 0 -56003041724.126526
Gr11_im_2_4 0 s2 x11_im_a4 0 10681040159.727543
Gr12_re_2_4 0 s2 x12_re_a4 0 -51470446193.19891
Gr12_im_2_4 0 s2 x12_im_a4 0 5083487698.24588
Gr13_2_4 0 s2 x13_a4 0 312266171.6700111
Gr14_2_4 0 s2 x14_a4 0 119268773296.20581
Gr15_2_4 0 s2 x15_a4 0 -127354016.39871365
*
* State networks driven by port 2
Cx1_a2 x1_a2 0 1.0
Gx1_a2 0 x1_a2 p2 0 0.07071067811865475
Fx1_a2 0 x1_a2 V2 3.5355339059327378
Rp1_a2 0 x1_a2 5.3127326297329175e-16
Cx2_re_a2 x2_re_a2 0 1.0
Gx2_re_a2 0 x2_re_a2 p2 0 0.1414213562373095
Fx2_re_a2 0 x2_re_a2 V2 7.0710678118654755
Rp2_re_re_a2 0 x2_re_a2 1.4491464268315856e-13
Gp2_re_im_a2 0 x2_re_a2 x2_im_a2 0 4060954945802.302
Cx2_im_a2 x2_im_a2 0 1.0
Gp2_im_re_a2 0 x2_im_a2 x2_re_a2 0 -4060954945802.302
Rp2_im_im_a2 0 x2_im_a2 1.4491464268315856e-13
Cx3_re_a2 x3_re_a2 0 1.0
Gx3_re_a2 0 x3_re_a2 p2 0 0.1414213562373095
Fx3_re_a2 0 x3_re_a2 V2 7.0710678118654755
Rp3_re_re_a2 0 x3_re_a2 9.654530001044516e-13
Gp3_re_im_a2 0 x3_re_a2 x3_im_a2 0 3789070885136.644
Cx3_im_a2 x3_im_a2 0 1.0
Gp3_im_re_a2 0 x3_im_a2 x3_re_a2 0 -3789070885136.644
Rp3_im_im_a2 0 x3_im_a2 9.654530001044516e-13
Cx4_re_a2 x4_re_a2 0 1.0
Gx4_re_a2 0 x4_re_a2 p2 0 0.1414213562373095
Fx4_re_a2 0 x4_re_a2 V2 7.0710678118654755
Rp4_re_re_a2 0 x4_re_a2 1.462282365376178e-12
Gp4_re_im_a2 0 x4_re_a2 x4_im_a2 0 2119527027660.7383
Cx4_im_a2 x4_im_a2 0 1.0
Gp4_im_re_a2 0 x4_im_a2 x4_re_a2 0 -2119527027660.7383
Rp4_im_im_a2 0 x4_im_a2 1.462282365376178e-12
Cx5_a2 x5_a2 0 1.0
Gx5_a2 0 x5_a2 p2 0 0.07071067811865475
Fx5_a2 0 x5_a2 V2 3.5355339059327378
Rp5_a2 0 x5_a2 5.585472429637349e-13
Cx6_re_a2 x6_re_a2 0 1.0
Gx6_re_a2 0 x6_re_a2 p2 0 0.1414213562373095
Fx6_re_a2 0 x6_re_a2 V2 7.0710678118654755
Rp6_re_re_a2 0 x6_re_a2 4.893534373781531e-12
Gp6_re_im_a2 0 x6_re_a2 x6_im_a2 0 1509987609831.2734
Cx6_im_a2 x6_im_a2 0 1.0
Gp6_im_re_a2 0 x6_im_a2 x6_re_a2 0 -1509987609831.2734
Rp6_im_im_a2 0 x6_im_a2 4.893534373781531e-12
Cx7_re_a2 x7_re_a2 0 1.0
Gx7_re_a2 0 x7_re_a2 p2 0 0.1414213562373095
Fx7_re_a2 0 x7_re_a2 V2 7.0710678118654755
Rp7_re_re_a2 0 x7_re_a2 2.29288470403448e-12
Gp7_re_im_a2 0 x7_re_a2 x7_im_a2 0 1394452077308.4116
Cx7_im_a2 x7_im_a2 0 1.0
Gp7_im_re_a2 0 x7_im_a2 x7_re_a2 0 -1394452077308.4116
Rp7_im_im_a2 0 x7_im_a2 2.29288470403448e-12
Cx8_re_a2 x8_re_a2 0 1.0
Gx8_re_a2 0 x8_re_a2 p2 0 0.1414213562373095
Fx8_re_a2 0 x8_re_a2 V2 7.0710678118654755
Rp8_re_re_a2 0 x8_re_a2 1.4913847089427331e-12
Gp8_re_im_a2 0 x8_re_a2 x8_im_a2 0 1216978368828.8792
Cx8_im_a2 x8_im_a2 0 1.0
Gp8_im_re_a2 0 x8_im_a2 x8_re_a2 0 -1216978368828.8792
Rp8_im_im_a2 0 x8_im_a2 1.4913847089427331e-12
Cx9_a2 x9_a2 0 1.0
Gx9_a2 0 x9_a2 p2 0 0.07071067811865475
Fx9_a2 0 x9_a2 V2 3.5355339059327378
Rp9_a2 0 x9_a2 8.726078094748571e-13
Cx10_re_a2 x10_re_a2 0 1.0
Gx10_re_a2 0 x10_re_a2 p2 0 0.1414213562373095
Fx10_re_a2 0 x10_re_a2 V2 7.0710678118654755
Rp10_re_re_a2 0 x10_re_a2 1.3660634868650793e-11
Gp10_re_im_a2 0 x10_re_a2 x10_im_a2 0 1018200886591.4563
Cx10_im_a2 x10_im_a2 0 1.0
Gp10_im_re_a2 0 x10_im_a2 x10_re_a2 0 -1018200886591.4563
Rp10_im_im_a2 0 x10_im_a2 1.3660634868650793e-11
Cx11_re_a2 x11_re_a2 0 1.0
Gx11_re_a2 0 x11_re_a2 p2 0 0.1414213562373095
Fx11_re_a2 0 x11_re_a2 V2 7.0710678118654755
Rp11_re_re_a2 0 x11_re_a2 2.8048472018812475e-12
Gp11_re_im_a2 0 x11_re_a2 x11_im_a2 0 1146809159475.6968
Cx11_im_a2 x11_im_a2 0 1.0
Gp11_im_re_a2 0 x11_im_a2 x11_re_a2 0 -1146809159475.6968
Rp11_im_im_a2 0 x11_im_a2 2.8048472018812475e-12
Cx12_re_a2 x12_re_a2 0 1.0
Gx12_re_a2 0 x12_re_a2 p2 0 0.1414213562373095
Fx12_re_a2 0 x12_re_a2 V2 7.0710678118654755
Rp12_re_re_a2 0 x12_re_a2 3.0396973742463667e-12
Gp12_re_im_a2 0 x12_re_a2 x12_im_a2 0 962334942598.3601
Cx12_im_a2 x12_im_a2 0 1.0
Gp12_im_re_a2 0 x12_im_a2 x12_re_a2 0 -962334942598.3601
Rp12_im_im_a2 0 x12_im_a2 3.0396973742463667e-12
Cx13_a2 x13_a2 0 1.0
Gx13_a2 0 x13_a2 p2 0 0.07071067811865475
Fx13_a2 0 x13_a2 V2 3.5355339059327378
Rp13_a2 0 x13_a2 8.623287421540062e-12
Cx14_a2 x14_a2 0 1.0
Gx14_a2 0 x14_a2 p2 0 0.07071067811865475
Fx14_a2 0 x14_a2 V2 3.5355339059327378
Rp14_a2 0 x14_a2 1.5587977849749075e-12
Cx15_a2 x15_a2 0 1.0
Gx15_a2 0 x15_a2 p2 0 0.07071067811865475
Fx15_a2 0 x15_a2 V2 3.5355339059327378
Rp15_a2 0 x15_a2 7.308577980835905e-12
*
* Port network for port 3
V3 p3 s3 0
R3 s3 0 50.0
Gd3_1 0 s3 p1 0 -0.0020772302137039974
Fd3_1 0 s3 V1 -0.10386151068519989
Gr1_3_1 0 s3 x1_a1 0 -50059884444813.35
Gr2_re_3_1 0 s3 x2_re_a1 0 523627698548.71606
Gr2_im_3_1 0 s3 x2_im_a1 0 137468512821.37814
Gr3_re_3_1 0 s3 x3_re_a1 0 -127640806287.17444
Gr3_im_3_1 0 s3 x3_im_a1 0 192810739328.23282
Gr4_re_3_1 0 s3 x4_re_a1 0 139966286577.9209
Gr4_im_3_1 0 s3 x4_im_a1 0 -42657804770.34025
Gr5_3_1 0 s3 x5_a1 0 128450121366.90642
Gr6_re_3_1 0 s3 x6_re_a1 0 19068775.976531487
Gr6_im_3_1 0 s3 x6_im_a1 0 7090105.549410041
Gr7_re_3_1 0 s3 x7_re_a1 0 191399906.39925197
Gr7_im_3_1 0 s3 x7_im_a1 0 558719923.2654713
Gr8_re_3_1 0 s3 x8_re_a1 0 2841269381.04729
Gr8_im_3_1 0 s3 x8_im_a1 0 -969933254.6255049
Gr9_3_1 0 s3 x9_a1 0 -44590173883.41983
Gr10_re_3_1 0 s3 x10_re_a1 0 -2.0592538731971444
Gr10_im_3_1 0 s3 x10_im_a1 0 1.4152458849451262
Gr11_re_3_1 0 s3 x11_re_a1 0 -56034134525.95908
Gr11_im_3_1 0 s3 x11_im_a1 0 10711136131.321417
Gr12_re_3_1 0 s3 x12_re_a1 0 -51442034729.34614
Gr12_im_3_1 0 s3 x12_im_a1 0 5098036674.662142
Gr13_3_1 0 s3 x13_a1 0 281940963.7387308
Gr14_3_1 0 s3 x14_a1 0 119579654469.92041
Gr15_3_1 0 s3 x15_a1 0 -98565502.5901227
Gd3_2 0 s3 p2 0 -0.008822351503302144
Fd3_2 0 s3 V2 -0.44111757516510725
Gr1_3_2 0 s3 x1_a2 0 -203424897673504.22
Gr2_re_3_2 0 s3 x2_re_a2 0 2833521192966.5293
Gr2_im_3_2 0 s3 x2_im_a2 0 3816321061712.9556
Gr3_re_3_2 0 s3 x3_re_a2 0 -90767425316.88593
Gr3_im_3_2 0 s3 x3_im_a2 0 -173898539524.8826
Gr4_re_3_2 0 s3 x4_re_a2 0 -130537957989.0077
Gr4_im_3_2 0 s3 x4_im_a2 0 31677116324.859875
Gr5_3_2 0 s3 x5_a2 0 131551326623.44193
Gr6_re_3_2 0 s3 x6_re_a2 0 5745809.442135985
Gr6_im_3_2 0 s3 x6_im_a2 0 -6939007.878773153
Gr7_re_3_2 0 s3 x7_re_a2 0 -50178577.253553905
Gr7_im_3_2 0 s3 x7_im_a2 0 282256298.4396942
Gr8_re_3_2 0 s3 x8_re_a2 0 -785084900.4496523
Gr8_im_3_2 0 s3 x8_im_a2 0 -1247381704.5916433
Gr9_3_2 0 s3 x9_a2 0 -27246080681.77528
Gr10_re_3_2 0 s3 x10_re_a2 0 -3.512368189629211
Gr10_im_3_2 0 s3 x10_im_a2 0 -3.4529442339509298
Gr11_re_3_2 0 s3 x11_re_a2 0 55982992529.19441
Gr11_im_3_2 0 s3 x11_im_a2 0 -10664297912.381538
Gr12_re_3_2 0 s3 x12_re_a2 0 -51465917635.82959
Gr12_im_3_2 0 s3 x12_im_a2 0 5063690981.588168
Gr13_3_2 0 s3 x13_a2 0 -4060022.4904777836
Gr14_3_2 0 s3 x14_a2 0 117215888606.85774
Gr15_3_2 0 s3 x15_a2 0 119648844.11396652
Gd3_3 0 s3 p3 0 -0.005312092513162823
Fd3_3 0 s3 V3 -0.26560462565814114
Gr1_3_3 0 s3 x1_a3 0 -121382739839143.25
Gr2_re_3_3 0 s3 x2_re_a3 0 1233551356706.9788
Gr2_im_3_3 0 s3 x2_im_a3 0 5650036389715.954
Gr3_re_3_3 0 s3 x3_re_a3 0 238042645206.08408
Gr3_im_3_3 0 s3 x3_im_a3 0 -197744331513.11374
Gr4_re_3_3 0 s3 x4_re_a3 0 81981003297.02956
Gr4_im_3_3 0 s3 x4_im_a3 0 -26478688080.391674
Gr5_3_3 0 s3 x5_a3 0 40343373181.79898
Gr6_re_3_3 0 s3 x6_re_a3 0 -28114411.355261452
Gr6_im_3_3 0 s3 x6_im_a3 0 -5888669.748983857
Gr7_re_3_3 0 s3 x7_re_a3 0 -234380145.73768544
Gr7_im_3_3 0 s3 x7_im_a3 0 -835950860.4921135
Gr8_re_3_3 0 s3 x8_re_a3 0 -3213536190.344082
Gr8_im_3_3 0 s3 x8_im_a3 0 -296806642.966119
Gr9_3_3 0 s3 x9_a3 0 -856300038.9452655
Gr10_re_3_3 0 s3 x10_re_a3 0 4.713930452424109
Gr10_im_3_3 0 s3 x10_im_a3 0 2.9995117169386405
Gr11_re_3_3 0 s3 x11_re_a3 0 56002184245.1554
Gr11_im_3_3 0 s3 x11_im_a3 0 -10681187670.449131
Gr12_re_3_3 0 s3 x12_re_a3 0 51441159735.27852
Gr12_im_3_3 0 s3 x12_im_a3 0 -5073500844.128513
Gr13_3_3 0 s3 x13_a3 0 -164503424.23045018
Gr14_3_3 0 s3 x14_a3 0 111410597363.93053
Gr15_3_3 0 s3 x15_a3 0 -212984673.18872997
Gd3_4 0 s3 p4 0 0.003320941912883218
Fd3_4 0 s3 V4 0.1660470956441609
Gr1_3_4 0 s3 x1_a4 0 75133663844820.38
Gr2_re_3_4 0 s3 x2_re_a4 0 -1211366573985.8875
Gr2_im_3_4 0 s3 x2_im_a4 0 -1638072379991.9775
Gr3_re_3_4 0 s3 x3_re_a4 0 165965657047.1448
Gr3_im_3_4 0 s3 x3_im_a4 0 41809401691.06975
Gr4_re_3_4 0 s3 x4_re_a4 0 -106093663271.4888
Gr4_im_3_4 0 s3 x4_im_a4 0 31268621115.30456
Gr5_3_4 0 s3 x5_a4 0 -8562428213.16343
Gr6_re_3_4 0 s3 x6_re_a4 0 7523962.786494806
Gr6_im_3_4 0 s3 x6_im_a4 0 3895060.904259181
Gr7_re_3_4 0 s3 x7_re_a4 0 169793868.79533994
Gr7_im_3_4 0 s3 x7_im_a4 0 -144502762.27806732
Gr8_re_3_4 0 s3 x8_re_a4 0 1478042791.6494524
Gr8_im_3_4 0 s3 x8_im_a4 0 1497830630.045432
Gr9_3_4 0 s3 x9_a4 0 -14071838397.502092
Gr10_re_3_4 0 s3 x10_re_a4 0 0.22458235627839596
Gr10_im_3_4 0 s3 x10_im_a4 0 1.24194296074646
Gr11_re_3_4 0 s3 x11_re_a4 0 -56021036260.84079
Gr11_im_3_4 0 s3 x11_im_a4 0 10681416923.314053
Gr12_re_3_4 0 s3 x12_re_a4 0 51445601699.73305
Gr12_im_3_4 0 s3 x12_im_a4 0 -5091149571.912641
Gr13_3_4 0 s3 x13_a4 0 58477404.2694693
Gr14_3_4 0 s3 x14_a4 0 116295417941.4188
Gr15_3_4 0 s3 x15_a4 0 -48875817.37563524
*
* State networks driven by port 3
Cx1_a3 x1_a3 0 1.0
Gx1_a3 0 x1_a3 p3 0 0.07071067811865475
Fx1_a3 0 x1_a3 V3 3.5355339059327378
Rp1_a3 0 x1_a3 5.3127326297329175e-16
Cx2_re_a3 x2_re_a3 0 1.0
Gx2_re_a3 0 x2_re_a3 p3 0 0.1414213562373095
Fx2_re_a3 0 x2_re_a3 V3 7.0710678118654755
Rp2_re_re_a3 0 x2_re_a3 1.4491464268315856e-13
Gp2_re_im_a3 0 x2_re_a3 x2_im_a3 0 4060954945802.302
Cx2_im_a3 x2_im_a3 0 1.0
Gp2_im_re_a3 0 x2_im_a3 x2_re_a3 0 -4060954945802.302
Rp2_im_im_a3 0 x2_im_a3 1.4491464268315856e-13
Cx3_re_a3 x3_re_a3 0 1.0
Gx3_re_a3 0 x3_re_a3 p3 0 0.1414213562373095
Fx3_re_a3 0 x3_re_a3 V3 7.0710678118654755
Rp3_re_re_a3 0 x3_re_a3 9.654530001044516e-13
Gp3_re_im_a3 0 x3_re_a3 x3_im_a3 0 3789070885136.644
Cx3_im_a3 x3_im_a3 0 1.0
Gp3_im_re_a3 0 x3_im_a3 x3_re_a3 0 -3789070885136.644
Rp3_im_im_a3 0 x3_im_a3 9.654530001044516e-13
Cx4_re_a3 x4_re_a3 0 1.0
Gx4_re_a3 0 x4_re_a3 p3 0 0.1414213562373095
Fx4_re_a3 0 x4_re_a3 V3 7.0710678118654755
Rp4_re_re_a3 0 x4_re_a3 1.462282365376178e-12
Gp4_re_im_a3 0 x4_re_a3 x4_im_a3 0 2119527027660.7383
Cx4_im_a3 x4_im_a3 0 1.0
Gp4_im_re_a3 0 x4_im_a3 x4_re_a3 0 -2119527027660.7383
Rp4_im_im_a3 0 x4_im_a3 1.462282365376178e-12
Cx5_a3 x5_a3 0 1.0
Gx5_a3 0 x5_a3 p3 0 0.07071067811865475
Fx5_a3 0 x5_a3 V3 3.5355339059327378
Rp5_a3 0 x5_a3 5.585472429637349e-13
Cx6_re_a3 x6_re_a3 0 1.0
Gx6_re_a3 0 x6_re_a3 p3 0 0.1414213562373095
Fx6_re_a3 0 x6_re_a3 V3 7.0710678118654755
Rp6_re_re_a3 0 x6_re_a3 4.893534373781531e-12
Gp6_re_im_a3 0 x6_re_a3 x6_im_a3 0 1509987609831.2734
Cx6_im_a3 x6_im_a3 0 1.0
Gp6_im_re_a3 0 x6_im_a3 x6_re_a3 0 -1509987609831.2734
Rp6_im_im_a3 0 x6_im_a3 4.893534373781531e-12
Cx7_re_a3 x7_re_a3 0 1.0
Gx7_re_a3 0 x7_re_a3 p3 0 0.1414213562373095
Fx7_re_a3 0 x7_re_a3 V3 7.0710678118654755
Rp7_re_re_a3 0 x7_re_a3 2.29288470403448e-12
Gp7_re_im_a3 0 x7_re_a3 x7_im_a3 0 1394452077308.4116
Cx7_im_a3 x7_im_a3 0 1.0
Gp7_im_re_a3 0 x7_im_a3 x7_re_a3 0 -1394452077308.4116
Rp7_im_im_a3 0 x7_im_a3 2.29288470403448e-12
Cx8_re_a3 x8_re_a3 0 1.0
Gx8_re_a3 0 x8_re_a3 p3 0 0.1414213562373095
Fx8_re_a3 0 x8_re_a3 V3 7.0710678118654755
Rp8_re_re_a3 0 x8_re_a3 1.4913847089427331e-12
Gp8_re_im_a3 0 x8_re_a3 x8_im_a3 0 1216978368828.8792
Cx8_im_a3 x8_im_a3 0 1.0
Gp8_im_re_a3 0 x8_im_a3 x8_re_a3 0 -1216978368828.8792
Rp8_im_im_a3 0 x8_im_a3 1.4913847089427331e-12
Cx9_a3 x9_a3 0 1.0
Gx9_a3 0 x9_a3 p3 0 0.07071067811865475
Fx9_a3 0 x9_a3 V3 3.5355339059327378
Rp9_a3 0 x9_a3 8.726078094748571e-13
Cx10_re_a3 x10_re_a3 0 1.0
Gx10_re_a3 0 x10_re_a3 p3 0 0.1414213562373095
Fx10_re_a3 0 x10_re_a3 V3 7.0710678118654755
Rp10_re_re_a3 0 x10_re_a3 1.3660634868650793e-11
Gp10_re_im_a3 0 x10_re_a3 x10_im_a3 0 1018200886591.4563
Cx10_im_a3 x10_im_a3 0 1.0
Gp10_im_re_a3 0 x10_im_a3 x10_re_a3 0 -1018200886591.4563
Rp10_im_im_a3 0 x10_im_a3 1.3660634868650793e-11
Cx11_re_a3 x11_re_a3 0 1.0
Gx11_re_a3 0 x11_re_a3 p3 0 0.1414213562373095
Fx11_re_a3 0 x11_re_a3 V3 7.0710678118654755
Rp11_re_re_a3 0 x11_re_a3 2.8048472018812475e-12
Gp11_re_im_a3 0 x11_re_a3 x11_im_a3 0 1146809159475.6968
Cx11_im_a3 x11_im_a3 0 1.0
Gp11_im_re_a3 0 x11_im_a3 x11_re_a3 0 -1146809159475.6968
Rp11_im_im_a3 0 x11_im_a3 2.8048472018812475e-12
Cx12_re_a3 x12_re_a3 0 1.0
Gx12_re_a3 0 x12_re_a3 p3 0 0.1414213562373095
Fx12_re_a3 0 x12_re_a3 V3 7.0710678118654755
Rp12_re_re_a3 0 x12_re_a3 3.0396973742463667e-12
Gp12_re_im_a3 0 x12_re_a3 x12_im_a3 0 962334942598.3601
Cx12_im_a3 x12_im_a3 0 1.0
Gp12_im_re_a3 0 x12_im_a3 x12_re_a3 0 -962334942598.3601
Rp12_im_im_a3 0 x12_im_a3 3.0396973742463667e-12
Cx13_a3 x13_a3 0 1.0
Gx13_a3 0 x13_a3 p3 0 0.07071067811865475
Fx13_a3 0 x13_a3 V3 3.5355339059327378
Rp13_a3 0 x13_a3 8.623287421540062e-12
Cx14_a3 x14_a3 0 1.0
Gx14_a3 0 x14_a3 p3 0 0.07071067811865475
Fx14_a3 0 x14_a3 V3 3.5355339059327378
Rp14_a3 0 x14_a3 1.5587977849749075e-12
Cx15_a3 x15_a3 0 1.0
Gx15_a3 0 x15_a3 p3 0 0.07071067811865475
Fx15_a3 0 x15_a3 V3 3.5355339059327378
Rp15_a3 0 x15_a3 7.308577980835905e-12
*
* Port network for port 4
V4 p4 s4 0
R4 s4 0 50.0
Gd4_1 0 s4 p1 0 -0.009637552741892512
Fd4_1 0 s4 V1 -0.4818776370946256
Gr1_4_1 0 s4 x1_a1 0 -221599423958809.72
Gr2_re_4_1 0 s4 x2_re_a1 0 3126774346139.2075
Gr2_im_4_1 0 s4 x2_im_a1 0 4415478036131.997
Gr3_re_4_1 0 s4 x3_re_a1 0 -96835283802.61705
Gr3_im_4_1 0 s4 x3_im_a1 0 -209791468399.8792
Gr4_re_4_1 0 s4 x4_re_a1 0 -132702225462.06093
Gr4_im_4_1 0 s4 x4_im_a1 0 28632256436.912403
Gr5_4_1 0 s4 x5_a1 0 164856225354.75043
Gr6_re_4_1 0 s4 x6_re_a1 0 -3685030.194017296
Gr6_im_4_1 0 s4 x6_im_a1 0 -9109126.629516322
Gr7_re_4_1 0 s4 x7_re_a1 0 -57194937.09476399
Gr7_im_4_1 0 s4 x7_im_a1 0 208824928.45477018
Gr8_re_4_1 0 s4 x8_re_a1 0 -909819995.6730576
Gr8_im_4_1 0 s4 x8_im_a1 0 -1610690405.8483915
Gr9_4_1 0 s4 x9_a1 0 -32344031007.902992
Gr10_re_4_1 0 s4 x10_re_a1 0 -3.7587772746325747
Gr10_im_4_1 0 s4 x10_im_a1 0 -2.8940033766185693
Gr11_re_4_1 0 s4 x11_re_a1 0 56057092217.8556
Gr11_im_4_1 0 s4 x11_im_a1 0 -10708658517.502747
Gr12_re_4_1 0 s4 x12_re_a1 0 -51446473998.47129
Gr12_im_4_1 0 s4 x12_im_a1 0 5114627102.389902
Gr13_4_1 0 s4 x13_a1 0 33333595.467554785
Gr14_4_1 0 s4 x14_a1 0 117547972396.39467
Gr15_4_1 0 s4 x15_a1 0 75448058.9172882
Gd4_2 0 s4 p2 0 0.005544639352599694
Fd4_2 0 s4 V2 0.27723196762998475
Gr1_4_2 0 s4 x1_a2 0 125730650417417.98
Gr2_re_4_2 0 s4 x2_re_a2 0 -1937329292239.8713
Gr2_im_4_2 0 s4 x2_im_a2 0 -3056808722638.472
Gr3_re_4_2 0 s4 x3_re_a2 0 19060187833.98556
Gr3_im_4_2 0 s4 x3_im_a2 0 296612198793.91534
Gr4_re_4_2 0 s4 x4_re_a2 0 149275530950.29477
Gr4_im_4_2 0 s4 x4_im_a2 0 -42043834758.86175
Gr5_4_2 0 s4 x5_a2 0 29710113825.982937
Gr6_re_4_2 0 s4 x6_re_a2 0 4990459.874260452
Gr6_im_4_2 0 s4 x6_im_a2 0 -1629103.0204872894
Gr7_re_4_2 0 s4 x7_re_a2 0 40056627.03599066
Gr7_im_4_2 0 s4 x7_im_a2 0 552315995.7586097
Gr8_re_4_2 0 s4 x8_re_a2 0 2923328476.8564596
Gr8_im_4_2 0 s4 x8_im_a2 0 310331634.8415259
Gr9_4_2 0 s4 x9_a2 0 -32762163308.06559
Gr10_re_4_2 0 s4 x10_re_a2 0 -1.6687691855970135
Gr10_im_4_2 0 s4 x10_im_a2 0 2.2815888336777004
Gr11_re_4_2 0 s4 x11_re_a2 0 -56003052895.378876
Gr11_im_4_2 0 s4 x11_im_a2 0 10681041553.925507
Gr12_re_4_2 0 s4 x12_re_a2 0 -51470446342.53041
Gr12_im_4_2 0 s4 x12_im_a2 0 5083486499.9433775
Gr13_4_2 0 s4 x13_a2 0 312277562.001228
Gr14_4_2 0 s4 x14_a2 0 119268514475.5549
Gr15_4_2 0 s4 x15_a2 0 -127365188.2035019
Gd4_3 0 s4 p3 0 0.0033204502059575114
Fd4_3 0 s4 V3 0.16602251029787557
Gr1_4_3 0 s4 x1_a3 0 75122550724339.34
Gr2_re_4_3 0 s4 x2_re_a3 0 -1211206915214.7646
Gr2_im_4_3 0 s4 x2_im_a3 0 -1637724191445.7744
Gr3_re_4_3 0 s4 x3_re_a3 0 165966124481.1284
Gr3_im_4_3 0 s4 x3_im_a3 0 41793713040.790146
Gr4_re_4_3 0 s4 x4_re_a3 0 -106093126497.9757
Gr4_im_4_3 0 s4 x4_im_a3 0 31266806430.54723
Gr5_4_3 0 s4 x5_a3 0 -8532410281.346146
Gr6_re_4_3 0 s4 x6_re_a3 0 7528458.0044542095
Gr6_im_4_3 0 s4 x6_im_a3 0 3893187.1926529496
Gr7_re_4_3 0 s4 x7_re_a3 0 169903839.5981401
Gr7_im_4_3 0 s4 x7_im_a3 0 -144514384.00227532
Gr8_re_4_3 0 s4 x8_re_a3 0 1478308738.2918787
Gr8_im_4_3 0 s4 x8_im_a3 0 1497394782.4955251
Gr9_4_3 0 s4 x9_a3 0 -14077286294.565475
Gr10_re_4_3 0 s4 x10_re_a3 0 0.2251797478351087
Gr10_im_4_3 0 s4 x10_im_a3 0 1.2655137220387145
Gr11_re_4_3 0 s4 x11_re_a3 0 -56021033757.40608
Gr11_im_4_3 0 s4 x11_im_a3 0 10681421731.453867
Gr12_re_4_3 0 s4 x12_re_a3 0 51445601134.131775
Gr12_im_4_3 0 s4 x12_im_a3 0 -5091149198.43728
Gr13_4_3 0 s4 x13_a3 0 58492753.648059435
Gr14_4_3 0 s4 x14_a3 0 116295639898.77406
Gr15_4_3 0 s4 x15_a3 0 -48895556.18173393
Gd4_4 0 s4 p4 0 -0.012161369268964146
Fd4_4 0 s4 V4 -0.6080684634482073
Gr1_4_4 0 s4 x1_a4 0 -278604875384021.25
Gr2_re_4_4 0 s4 x2_re_a4 0 3486278453131.5503
Gr2_im_4_4 0 s4 x2_im_a4 0 8801153812884.066
Gr3_re_4_4 0 s4 x3_re_a4 0 114999432276.66786
Gr3_im_4_4 0 s4 x3_im_a4 0 -316695405316.99194
Gr4_re_4_4 0 s4 x4_re_a4 0 72566618002.96425
Gr4_im_4_4 0 s4 x4_im_a4 0 -30409607841.70747
Gr5_4_4 0 s4 x5_a4 0 149762376912.7038
Gr6_re_4_4 0 s4 x6_re_a4 0 -23029893.9668796
Gr6_im_4_4 0 s4 x6_im_a4 0 -632513.7056192745
Gr7_re_4_4 0 s4 x7_re_a4 0 -89291337.19533692
Gr7_im_4_4 0 s4 x7_im_a4 0 -877713423.0131812
Gr8_re_4_4 0 s4 x8_re_a4 0 -3353145607.6097627
Gr8_im_4_4 0 s4 x8_im_a4 0 -1814089609.9574351
Gr9_4_4 0 s4 x9_a4 0 -14514459898.858469
Gr10_re_4_4 0 s4 x10_re_a4 0 4.39587993469399
Gr10_im_4_4 0 s4 x10_im_a4 0 2.4446336565771527
Gr11_re_4_4 0 s4 x11_re_a4 0 56044723091.35275
Gr11_im_4_4 0 s4 x11_im_a4 0 -10695634110.514309
Gr12_re_4_4 0 s4 x12_re_a4 0 51450071425.65378
Gr12_im_4_4 0 s4 x12_im_a4 0 -5109844439.364581
Gr13_4_4 0 s4 x13_a4 0 -203242324.57266575
Gr14_4_4 0 s4 x14_a4 0 111895149251.88019
Gr15_4_4 0 s4 x15_a4 0 -175897957.48375696
*
* State networks driven by port 4
Cx1_a4 x1_a4 0 1.0
Gx1_a4 0 x1_a4 p4 0 0.07071067811865475
Fx1_a4 0 x1_a4 V4 3.5355339059327378
Rp1_a4 0 x1_a4 5.3127326297329175e-16
Cx2_re_a4 x2_re_a4 0 1.0
Gx2_re_a4 0 x2_re_a4 p4 0 0.1414213562373095
Fx2_re_a4 0 x2_re_a4 V4 7.0710678118654755
Rp2_re_re_a4 0 x2_re_a4 1.4491464268315856e-13
Gp2_re_im_a4 0 x2_re_a4 x2_im_a4 0 4060954945802.302
Cx2_im_a4 x2_im_a4 0 1.0
Gp2_im_re_a4 0 x2_im_a4 x2_re_a4 0 -4060954945802.302
Rp2_im_im_a4 0 x2_im_a4 1.4491464268315856e-13
Cx3_re_a4 x3_re_a4 0 1.0
Gx3_re_a4 0 x3_re_a4 p4 0 0.1414213562373095
Fx3_re_a4 0 x3_re_a4 V4 7.0710678118654755
Rp3_re_re_a4 0 x3_re_a4 9.654530001044516e-13
Gp3_re_im_a4 0 x3_re_a4 x3_im_a4 0 3789070885136.644
Cx3_im_a4 x3_im_a4 0 1.0
Gp3_im_re_a4 0 x3_im_a4 x3_re_a4 0 -3789070885136.644
Rp3_im_im_a4 0 x3_im_a4 9.654530001044516e-13
Cx4_re_a4 x4_re_a4 0 1.0
Gx4_re_a4 0 x4_re_a4 p4 0 0.1414213562373095
Fx4_re_a4 0 x4_re_a4 V4 7.0710678118654755
Rp4_re_re_a4 0 x4_re_a4 1.462282365376178e-12
Gp4_re_im_a4 0 x4_re_a4 x4_im_a4 0 2119527027660.7383
Cx4_im_a4 x4_im_a4 0 1.0
Gp4_im_re_a4 0 x4_im_a4 x4_re_a4 0 -2119527027660.7383
Rp4_im_im_a4 0 x4_im_a4 1.462282365376178e-12
Cx5_a4 x5_a4 0 1.0
Gx5_a4 0 x5_a4 p4 0 0.07071067811865475
Fx5_a4 0 x5_a4 V4 3.5355339059327378
Rp5_a4 0 x5_a4 5.585472429637349e-13
Cx6_re_a4 x6_re_a4 0 1.0
Gx6_re_a4 0 x6_re_a4 p4 0 0.1414213562373095
Fx6_re_a4 0 x6_re_a4 V4 7.0710678118654755
Rp6_re_re_a4 0 x6_re_a4 4.893534373781531e-12
Gp6_re_im_a4 0 x6_re_a4 x6_im_a4 0 1509987609831.2734
Cx6_im_a4 x6_im_a4 0 1.0
Gp6_im_re_a4 0 x6_im_a4 x6_re_a4 0 -1509987609831.2734
Rp6_im_im_a4 0 x6_im_a4 4.893534373781531e-12
Cx7_re_a4 x7_re_a4 0 1.0
Gx7_re_a4 0 x7_re_a4 p4 0 0.1414213562373095
Fx7_re_a4 0 x7_re_a4 V4 7.0710678118654755
Rp7_re_re_a4 0 x7_re_a4 2.29288470403448e-12
Gp7_re_im_a4 0 x7_re_a4 x7_im_a4 0 1394452077308.4116
Cx7_im_a4 x7_im_a4 0 1.0
Gp7_im_re_a4 0 x7_im_a4 x7_re_a4 0 -1394452077308.4116
Rp7_im_im_a4 0 x7_im_a4 2.29288470403448e-12
Cx8_re_a4 x8_re_a4 0 1.0
Gx8_re_a4 0 x8_re_a4 p4 0 0.1414213562373095
Fx8_re_a4 0 x8_re_a4 V4 7.0710678118654755
Rp8_re_re_a4 0 x8_re_a4 1.4913847089427331e-12
Gp8_re_im_a4 0 x8_re_a4 x8_im_a4 0 1216978368828.8792
Cx8_im_a4 x8_im_a4 0 1.0
Gp8_im_re_a4 0 x8_im_a4 x8_re_a4 0 -1216978368828.8792
Rp8_im_im_a4 0 x8_im_a4 1.4913847089427331e-12
Cx9_a4 x9_a4 0 1.0
Gx9_a4 0 x9_a4 p4 0 0.07071067811865475
Fx9_a4 0 x9_a4 V4 3.5355339059327378
Rp9_a4 0 x9_a4 8.726078094748571e-13
Cx10_re_a4 x10_re_a4 0 1.0
Gx10_re_a4 0 x10_re_a4 p4 0 0.1414213562373095
Fx10_re_a4 0 x10_re_a4 V4 7.0710678118654755
Rp10_re_re_a4 0 x10_re_a4 1.3660634868650793e-11
Gp10_re_im_a4 0 x10_re_a4 x10_im_a4 0 1018200886591.4563
Cx10_im_a4 x10_im_a4 0 1.0
Gp10_im_re_a4 0 x10_im_a4 x10_re_a4 0 -1018200886591.4563
Rp10_im_im_a4 0 x10_im_a4 1.3660634868650793e-11
Cx11_re_a4 x11_re_a4 0 1.0
Gx11_re_a4 0 x11_re_a4 p4 0 0.1414213562373095
Fx11_re_a4 0 x11_re_a4 V4 7.0710678118654755
Rp11_re_re_a4 0 x11_re_a4 2.8048472018812475e-12
Gp11_re_im_a4 0 x11_re_a4 x11_im_a4 0 1146809159475.6968
Cx11_im_a4 x11_im_a4 0 1.0
Gp11_im_re_a4 0 x11_im_a4 x11_re_a4 0 -1146809159475.6968
Rp11_im_im_a4 0 x11_im_a4 2.8048472018812475e-12
Cx12_re_a4 x12_re_a4 0 1.0
Gx12_re_a4 0 x12_re_a4 p4 0 0.1414213562373095
Fx12_re_a4 0 x12_re_a4 V4 7.0710678118654755
Rp12_re_re_a4 0 x12_re_a4 3.0396973742463667e-12
Gp12_re_im_a4 0 x12_re_a4 x12_im_a4 0 962334942598.3601
Cx12_im_a4 x12_im_a4 0 1.0
Gp12_im_re_a4 0 x12_im_a4 x12_re_a4 0 -962334942598.3601
Rp12_im_im_a4 0 x12_im_a4 3.0396973742463667e-12
Cx13_a4 x13_a4 0 1.0
Gx13_a4 0 x13_a4 p4 0 0.07071067811865475
Fx13_a4 0 x13_a4 V4 3.5355339059327378
Rp13_a4 0 x13_a4 8.623287421540062e-12
Cx14_a4 x14_a4 0 1.0
Gx14_a4 0 x14_a4 p4 0 0.07071067811865475
Fx14_a4 0 x14_a4 V4 3.5355339059327378
Rp14_a4 0 x14_a4 1.5587977849749075e-12
Cx15_a4 x15_a4 0 1.0
Gx15_a4 0 x15_a4 p4 0 0.07071067811865475
Fx15_a4 0 x15_a4 V4 3.5355339059327378
Rp15_a4 0 x15_a4 7.308577980835905e-12
.ENDS s_equivalent
