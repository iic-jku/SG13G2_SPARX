* Extracted by KLayout with SG13G2 LVS runset on : 05/04/2026 19:28

.SUBCKT sparx160_powdet_sbd vss vout vref vdd
R$1 vdd \$I53 vss rhigh w=0.5u l=2u ps=0u b=0 m=1
R$2 \$I53 \$I38 vss rsil w=0.5u l=2.5u ps=0u b=0 m=1
R$3 \$I53 \$12 vss rsil w=0.5u l=2.5u ps=0u b=0 m=1
D$4 \$12 \$I28 vss schottky_nbl1 m=1
D$5 \$I38 \$I19 vss schottky_nbl1 m=1
R$6 \$I19 vref vss rppd w=0.5u l=1.5u ps=0u b=0 m=1
R$7 vout \$I28 vss rppd w=0.5u l=1.5u ps=0u b=0 m=1
M$8 vdd vdd vdd \$I71 sg13_lv_pmos L=0.13u W=10u AS=2.65p AD=2.65p PS=16.06u
+ PD=16.06u rfmode=0
M$9 vdd \$I28 vout \$I71 sg13_lv_pmos L=0.13u W=100u AS=19p AD=19p PS=107.6u
+ PD=107.6u rfmode=0
M$19 vdd \$I19 vref \$I71 sg13_lv_pmos L=0.13u W=10u AS=1.9p AD=1.9p PS=10.76u
+ PD=10.76u rfmode=0
R$32 vdd \$I71 ntap1 A=15.708p P=104.72u
M$33 vss vss vss vss sg13_lv_nmos L=0.13u W=5u AS=1.325p AD=1.325p PS=8.56u
+ PD=8.56u rfmode=0
M$34 vss \$I28 vout vss sg13_lv_nmos L=0.13u W=50u AS=9.5p AD=9.5p PS=57.6u
+ PD=57.6u rfmode=0
M$44 vss \$I19 vref vss sg13_lv_nmos L=0.13u W=5u AS=0.95p AD=0.95p PS=5.76u
+ PD=5.76u rfmode=0
R$57 vss vss ptap1 A=13.68p P=91.2u
.ENDS sparx160_powdet_sbd
