* Extracted by KLayout with SG13G2 LVS runset on : 07/04/2026 10:45

.SUBCKT sparx160_powdet_sbd vout vref vss vdd rfin
C$1 rfin \$14 \$1 rfcmim w=0u l=0u A=0p P=0u m=1 wfeed=0u
R$2 vdd \$I73 \$1 rhigh w=0.5u l=2u ps=0u b=0 m=1
C$3 vdd vss cap_cmim w=6.8u l=9u A=61.2p P=31.6u m=2
R$5 \$I73 \$I37 \$1 rsil w=0.5u l=2.5u ps=0u b=0 m=1
R$6 \$I73 \$14 \$1 rsil w=0.5u l=2.5u ps=0u b=0 m=1
D$7 \$14 \$I27 \$1 schottky_nbl1 m=1
D$8 \$I37 \$I18 \$1 schottky_nbl1 m=1
R$9 \$I18 vref \$1 rppd w=0.5u l=1.5u ps=0u b=0 m=1
R$10 vout \$I27 \$1 rppd w=0.5u l=1.5u ps=0u b=0 m=1
M$11 vdd vdd vdd \$I76 sg13_lv_pmos L=0.13u W=10u AS=2.65p AD=2.65p PS=16.06u
+ PD=16.06u rfmode=0
M$12 vdd \$I27 vout \$I76 sg13_lv_pmos L=0.13u W=100u AS=19p AD=19p PS=107.6u
+ PD=107.6u rfmode=0
M$22 vdd \$I18 vref \$I76 sg13_lv_pmos L=0.13u W=10u AS=1.9p AD=1.9p PS=10.76u
+ PD=10.76u rfmode=0
R$35 vdd \$I76 ntap1 A=15.708p P=104.72u
M$36 vss vss vss \$1 sg13_lv_nmos L=0.13u W=5u AS=1.325p AD=1.325p PS=8.56u
+ PD=8.56u rfmode=0
M$37 vss \$I27 vout \$1 sg13_lv_nmos L=0.13u W=50u AS=9.5p AD=9.5p PS=57.6u
+ PD=57.6u rfmode=0
M$47 vss \$I18 vref \$1 sg13_lv_nmos L=0.13u W=5u AS=0.95p AD=0.95p PS=5.76u
+ PD=5.76u rfmode=0
R$60 vss \$1 ptap1 A=13.68p P=91.2u
.ENDS sparx160_powdet_sbd
