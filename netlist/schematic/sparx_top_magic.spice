** sch_path: /foss/designs/SG13G2_SPARX/schematic/sparx_top.sch
.subckt sparx_top

.ends
