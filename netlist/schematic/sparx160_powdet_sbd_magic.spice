** sch_path: /foss/designs/SG13G2_SPARX160/schematic/sparx160_powdet_sbd.sch
.subckt sparx160_powdet_sbd

.ends
